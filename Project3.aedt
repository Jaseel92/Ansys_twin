# Ansys Electronics Desktop project, version 2023.2
materials:
  vacuum: permittivity=1
  pec: conductivity=1e+30
  PMLGroup1_Z_1: permittivity{anisotropic component1=1.3004152 component2=1.3004152 component3=0.38449259} permeability{anisotropic component1=1.3004152 component2=1.3004152 component3=0.38449259} dielectric_loss_tangent{anisotropic component1=1 component2=1 component3=-1} magnetic_loss_tangent{anisotropic component1=1 component2=1 component3=-1}
  PMLGroup1_XZ_1: permittivity{anisotropic component1=1 component2=0.01 component3=1} permeability{anisotropic component1=1 component2=0.01 component3=1} dielectric_loss_tangent{anisotropic component1=0 component2=338.21593 component3=0} magnetic_loss_tangent{anisotropic component1=0 component2=338.21593 component3=0}
  PMLGroup1_YZ_1: permittivity{anisotropic component1=0.01 component2=1 component3=1} permeability{anisotropic component1=0.01 component2=1 component3=1} dielectric_loss_tangent{anisotropic component1=338.21593 component2=0 component3=0} magnetic_loss_tangent{anisotropic component1=338.21593 component2=0 component3=0}
  PMLGroup1_XYZ_1: permittivity{anisotropic component1=1.3004152 component2=1.3004152 component3=1.3004152} permeability{anisotropic component1=1.3004152 component2=1.3004152 component3=1.3004152} dielectric_loss_tangent{anisotropic component1=1 component2=1 component3=1} magnetic_loss_tangent{anisotropic component1=1 component2=1 component3=1}

design HFSSDesign1 (HFSS, HFSS Modal Network, model units mm)
geometry:
  dip1 [pec] = cylinder(axis=Z, base_centre=(0mm, 0mm, 1mm), radius=1mm, height=8mm)
  dip2 [pec] = cylinder(axis=Z, base_centre=(0mm, 0mm, -1mm), radius=1mm, height=-8mm)
  Rectangle1 = rectangle(corner=(0mm, -1mm, -1mm), y_size=2mm, z_size=2mm)
  RadiatingSurface [vacuum] = region(absolute_offset=10.416667mm on all sides)
  coordinate_system FaceCS1 = face of RadiatingSurface: Origin=(11.416667, -11.416667, 19.416667) FaceID=RadiatingSurface.face(+z) AxisPosn=(11.416667, 11.416667, 19.416667) WhichAxis=X ZRotationAngle=0deg XOffset=0mm YOffset=0mm FaceNormal(0, 0, 1)
  PML_RadiatingSurface_1 [PMLGroup1_Z_1, oriented by FaceCS1] = sweep_along_normal(RadiatingSurface.face(+z), length=14.326933mm)
  coordinate_system FaceCS2 = face of RadiatingSurface: Origin=(11.416667, -11.416667, -19.416667) FaceID=RadiatingSurface.face(-z) AxisPosn=(-11.416667, -11.416667, -19.416667) WhichAxis=X ZRotationAngle=0deg XOffset=0mm YOffset=0mm FaceNormal(0, 0, -1)
  PML_RadiatingSurface_2 [PMLGroup1_Z_1, oriented by FaceCS2] = sweep_along_normal(RadiatingSurface.face(-z), length=14.326933mm)
  coordinate_system FaceCS3 = face of RadiatingSurface: Origin=(11.416667, -11.416667, 19.416667) FaceID=RadiatingSurface.face(-y) AxisPosn=(-11.416667, -11.416667, 19.416667) WhichAxis=X ZRotationAngle=0deg XOffset=0mm YOffset=0mm FaceNormal(0, -1, 0)
  PML_RadiatingSurface_3 [PMLGroup1_Z_1, oriented by FaceCS3] = sweep_along_normal(RadiatingSurface.face(-y), length=14.326933mm)
  coordinate_system FaceCS4 = face of RadiatingSurface: Origin=(-11.416667, -11.416667, 19.416667) FaceID=RadiatingSurface.face(-x) AxisPosn=(-11.416667, 11.416667, 19.416667) WhichAxis=X ZRotationAngle=0deg XOffset=0mm YOffset=0mm FaceNormal(-1, 0, 0)
  PML_RadiatingSurface_4 [PMLGroup1_Z_1, oriented by FaceCS4] = sweep_along_normal(RadiatingSurface.face(-x), length=14.326933mm)
  coordinate_system FaceCS5 = face of RadiatingSurface: Origin=(-11.416667, 11.416667, 19.416667) FaceID=RadiatingSurface.face(+y) AxisPosn=(11.416667, 11.416667, 19.416667) WhichAxis=X ZRotationAngle=0deg XOffset=0mm YOffset=0mm FaceNormal(0, 1, 0)
  PML_RadiatingSurface_5 [PMLGroup1_Z_1, oriented by FaceCS5] = sweep_along_normal(RadiatingSurface.face(+y), length=14.326933mm)
  coordinate_system FaceCS6 = face of RadiatingSurface: Origin=(11.416667, 11.416667, -19.416667) FaceID=RadiatingSurface.face(+x) AxisPosn=(11.416667, 11.416667, 19.416667) WhichAxis=X ZRotationAngle=0deg XOffset=0mm YOffset=0mm FaceNormal(1, 0, 0)
  PML_RadiatingSurface_6 [PMLGroup1_Z_1, oriented by FaceCS6] = sweep_along_normal(RadiatingSurface.face(+x), length=14.326933mm)
  PML_RadiatingSurface_7 [PMLGroup1_XZ_1, oriented by FaceCS1] = sweep_along_normal(PML_RadiatingSurface_1.face(at (0, -11.4167, 26.5801)), length=14.326933mm)
  PML_RadiatingSurface_8 [PMLGroup1_YZ_1, oriented by FaceCS4] = sweep_along_normal(PML_RadiatingSurface_1.face(at (-11.4167, 0, 26.5801)), length=14.326933mm)
  PML_RadiatingSurface_9 [PMLGroup1_YZ_1, oriented by FaceCS5] = sweep_along_normal(PML_RadiatingSurface_1.face(at (0, 11.4167, 26.5801)), length=14.326933mm)
  PML_RadiatingSurface_10 [PMLGroup1_YZ_1, oriented by FaceCS1] = sweep_along_normal(PML_RadiatingSurface_1.face(at (11.4167, 0, 26.5801)), length=14.326933mm)
  PML_RadiatingSurface_11 [PMLGroup1_YZ_1, oriented by FaceCS2] = sweep_along_normal(PML_RadiatingSurface_2.face(at (0, -11.4167, -26.5801)), length=14.326933mm)
  coordinate_system FaceCS7 = face of RadiatingSurface: Origin=(-11.416667, -11.416667, -19.416667) FaceID=RadiatingSurface.face(-z) AxisPosn=(-11.416667, 11.416667, -19.416667) WhichAxis=X ZRotationAngle=0deg XOffset=0mm YOffset=0mm FaceNormal(0, 0, -1)
  PML_RadiatingSurface_12 [PMLGroup1_YZ_1, oriented by FaceCS7] = sweep_along_normal(PML_RadiatingSurface_2.face(at (-11.4167, 0, -26.5801)), length=14.326933mm)
  coordinate_system FaceCS8 = face of RadiatingSurface: Origin=(-11.416667, 11.416667, -19.416667) FaceID=RadiatingSurface.face(-z) AxisPosn=(11.416667, 11.416667, -19.416667) WhichAxis=X ZRotationAngle=0deg XOffset=0mm YOffset=0mm FaceNormal(0, 0, -1)
  PML_RadiatingSurface_13 [PMLGroup1_YZ_1, oriented by FaceCS8] = sweep_along_normal(PML_RadiatingSurface_2.face(at (0, 11.4167, -26.5801)), length=14.326933mm)
  PML_RadiatingSurface_14 [PMLGroup1_XZ_1, oriented by FaceCS2] = sweep_along_normal(PML_RadiatingSurface_2.face(at (11.4167, 0, -26.5801)), length=14.326933mm)
  PML_RadiatingSurface_15 [PMLGroup1_XZ_1, oriented by FaceCS4] = sweep_along_normal(PML_RadiatingSurface_3.face(at (-11.4167, -18.5801, 0)), length=14.326933mm)
  PML_RadiatingSurface_16 [PMLGroup1_XZ_1, oriented by FaceCS3] = sweep_along_normal(PML_RadiatingSurface_3.face(at (11.4167, -18.5801, 0)), length=14.326933mm)
  PML_RadiatingSurface_17 [PMLGroup1_XZ_1, oriented by FaceCS5] = sweep_along_normal(PML_RadiatingSurface_4.face(at (-18.5801, 11.4167, 0)), length=14.326933mm)
  PML_RadiatingSurface_18 [PMLGroup1_YZ_1, oriented by FaceCS6] = sweep_along_normal(PML_RadiatingSurface_5.face(at (11.4167, 18.5801, 0)), length=14.326933mm)
  PML_RadiatingSurface_19 [PMLGroup1_XYZ_1, oriented by FaceCS4] = sweep_along_normal(PML_RadiatingSurface_7.face(at (-11.4167, -18.5801, 26.5801)), length=14.326933mm)
  PML_RadiatingSurface_20 [PMLGroup1_XYZ_1, oriented by FaceCS1] = sweep_along_normal(PML_RadiatingSurface_7.face(at (11.4167, -18.5801, 26.5801)), length=14.326933mm)
  PML_RadiatingSurface_21 [PMLGroup1_XYZ_1, oriented by FaceCS5] = sweep_along_normal(PML_RadiatingSurface_8.face(at (-18.5801, 11.4167, 26.5801)), length=14.326933mm)
  coordinate_system FaceCS9 = face of RadiatingSurface: Origin=(11.416667, 11.416667, 19.416667) FaceID=RadiatingSurface.face(+z) AxisPosn=(-11.416667, 11.416667, 19.416667) WhichAxis=X ZRotationAngle=0deg XOffset=0mm YOffset=0mm FaceNormal(0, 0, 1)
  PML_RadiatingSurface_22 [PMLGroup1_XYZ_1, oriented by FaceCS9] = sweep_along_normal(PML_RadiatingSurface_9.face(at (11.4167, 18.5801, 26.5801)), length=14.326933mm)
  PML_RadiatingSurface_23 [PMLGroup1_XYZ_1, oriented by FaceCS7] = sweep_along_normal(PML_RadiatingSurface_11.face(at (-11.4167, -18.5801, -26.5801)), length=14.326933mm)
  PML_RadiatingSurface_24 [PMLGroup1_XYZ_1, oriented by FaceCS2] = sweep_along_normal(PML_RadiatingSurface_11.face(at (11.4167, -18.5801, -26.5801)), length=14.326933mm)
  PML_RadiatingSurface_25 [PMLGroup1_XYZ_1, oriented by FaceCS8] = sweep_along_normal(PML_RadiatingSurface_12.face(at (-18.5801, 11.4167, -26.5801)), length=14.326933mm)
  PML_RadiatingSurface_26 [PMLGroup1_XYZ_1, oriented by FaceCS6] = sweep_along_normal(PML_RadiatingSurface_13.face(at (11.4167, 18.5801, -26.5801)), length=14.326933mm)
  group PMLGroup1 = PML_RadiatingSurface_1..PML_RadiatingSurface_26
boundaries and excitations:
  PML_radiation1: Radiation Faces=RadiatingSurface.face(+z) IsForPML
  PML_radiation2: Radiation Faces=RadiatingSurface.face(-z) IsForPML
  PML_radiation3: Radiation Faces=RadiatingSurface.face(-y) IsForPML
  PML_radiation4: Radiation Faces=RadiatingSurface.face(-x) IsForPML
  PML_radiation5: Radiation Faces=RadiatingSurface.face(+y) IsForPML
  PML_radiation6: Radiation Faces=RadiatingSurface.face(+x) IsForPML
  1: Lumped Port Objects=Rectangle1 LumpedPortType=Default Modes{Mode1{IntLine{(0, 0, -1) -> (0, 0, 1)} CharImp=Zpi RenormImp=50ohm}} Impedance=50ohm
setups:
  Setup1: HfssDriven Frequency=7.2GHz MaxDeltaS=0.02 MaximumPasses=6 MinimumPasses=1 MinimumConvergedPasses=1 PercentRefinement=30 BasisOrder=1 PortAccuracy=2 DrivenSolverType="Direct Solver"
    sweep Sweep: 3.6GHz to 10.8GHz, 401 points; Type=Interpolating InterpTolerance=0.5 InterpMaxSolns=250 InterpUsePortImped=false PassivityErrorTolerance=0.0001
source amplitudes:
  1:1: 1W 0deg
radiation setups:
  3D: Infinite Sphere Theta=0deg..180deg step 2deg Phi=-180deg..180deg step 2deg
  Elevation: Infinite Sphere Theta=-180deg..180deg step 1deg Phi=0deg..90deg step 90deg
  Azimuth: Infinite Sphere Theta=90deg..90deg step 0deg Phi=-180deg..180deg step 1deg
reports:
  S Parameter Plot 1: dB(S(1,1)) vs Freq on Setup1 : Sweep
  S Parameter Plot 2: dB(S(1,1)) vs Freq on Setup1 : Sweep
