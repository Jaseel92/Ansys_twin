# Ansys Electronics Desktop project, version 2023.2
materials:
  vacuum: permittivity=1
  copper: permeability=0.999991 conductivity=58000000
  pec: conductivity=1e+30
  PMLGroup1_Z_1: permittivity{anisotropic component1=1.3898825 component2=1.3898825 component3=0.35974263} permeability{anisotropic component1=1.3898825 component2=1.3898825 component3=0.35974263} dielectric_loss_tangent{anisotropic component1=1 component2=1 component3=-1} magnetic_loss_tangent{anisotropic component1=1 component2=1 component3=-1}
  PMLGroup1_XZ_1: permittivity{anisotropic component1=1 component2=0.01 component3=1} permeability{anisotropic component1=1 component2=0.01 component3=1} dielectric_loss_tangent{anisotropic component1=0 component2=386.35469 component3=0} magnetic_loss_tangent{anisotropic component1=0 component2=386.35469 component3=0}
  PMLGroup1_YZ_1: permittivity{anisotropic component1=0.01 component2=1 component3=1} permeability{anisotropic component1=0.01 component2=1 component3=1} dielectric_loss_tangent{anisotropic component1=386.35469 component2=0 component3=0} magnetic_loss_tangent{anisotropic component1=386.35469 component2=0 component3=0}
  PMLGroup1_XYZ_1: permittivity{anisotropic component1=1.3898825 component2=1.3898825 component3=1.3898825} permeability{anisotropic component1=1.3898825 component2=1.3898825 component3=1.3898825} dielectric_loss_tangent{anisotropic component1=1 component2=1 component3=1} magnetic_loss_tangent{anisotropic component1=1 component2=1 component3=1}

design HFSSDesign1 (HFSS, HFSS Modal Network, model units mm)
variables:
  dl = 150mm
  dr = 1mm
  gl = 1mm
geometry:
  Dipole [pec] = cylinder(axis=Z, base_centre=(0mm, 0mm, -dl/2), radius=dr, height=dl)
  gap [vacuum] = cylinder(axis=Z, base_centre=(0mm, 0mm, -gl/2), radius=dr, height=gl)
  gap_1 = gap.copy()
  Dipole.subtract(gap_1)
  P1 = gap.section(plane=YZ)
  RadiatingSurface [vacuum] = region(absolute_offset=75mm on all sides)
  coordinate_system FaceCS1 = face of RadiatingSurface: Origin=(76, -76, 150) FaceID=RadiatingSurface.face(+z) AxisPosn=(76, 76, 150) WhichAxis=X ZRotationAngle=0deg XOffset=0mm YOffset=0mm FaceNormal(0, 0, 1)
  PML_RadiatingSurface_1 [PMLGroup1_Z_1, oriented by FaceCS1] = sweep_along_normal(RadiatingSurface.face(+z), length=96.513855mm)
  coordinate_system FaceCS2 = face of RadiatingSurface: Origin=(76, -76, -150) FaceID=RadiatingSurface.face(-z) AxisPosn=(-76, -76, -150) WhichAxis=X ZRotationAngle=0deg XOffset=0mm YOffset=0mm FaceNormal(0, 0, -1)
  PML_RadiatingSurface_2 [PMLGroup1_Z_1, oriented by FaceCS2] = sweep_along_normal(RadiatingSurface.face(-z), length=96.513855mm)
  coordinate_system FaceCS3 = face of RadiatingSurface: Origin=(76, -76, 150) FaceID=RadiatingSurface.face(-y) AxisPosn=(-76, -76, 150) WhichAxis=X ZRotationAngle=0deg XOffset=0mm YOffset=0mm FaceNormal(0, -1, 0)
  PML_RadiatingSurface_3 [PMLGroup1_Z_1, oriented by FaceCS3] = sweep_along_normal(RadiatingSurface.face(-y), length=96.513855mm)
  coordinate_system FaceCS4 = face of RadiatingSurface: Origin=(-76, -76, 150) FaceID=RadiatingSurface.face(-x) AxisPosn=(-76, 76, 150) WhichAxis=X ZRotationAngle=0deg XOffset=0mm YOffset=0mm FaceNormal(-1, 0, 0)
  PML_RadiatingSurface_4 [PMLGroup1_Z_1, oriented by FaceCS4] = sweep_along_normal(RadiatingSurface.face(-x), length=96.513855mm)
  coordinate_system FaceCS5 = face of RadiatingSurface: Origin=(-76, 76, 150) FaceID=RadiatingSurface.face(+y) AxisPosn=(76, 76, 150) WhichAxis=X ZRotationAngle=0deg XOffset=0mm YOffset=0mm FaceNormal(0, 1, 0)
  PML_RadiatingSurface_5 [PMLGroup1_Z_1, oriented by FaceCS5] = sweep_along_normal(RadiatingSurface.face(+y), length=96.513855mm)
  coordinate_system FaceCS6 = face of RadiatingSurface: Origin=(76, 76, -150) FaceID=RadiatingSurface.face(+x) AxisPosn=(76, 76, 150) WhichAxis=X ZRotationAngle=0deg XOffset=0mm YOffset=0mm FaceNormal(1, 0, 0)
  PML_RadiatingSurface_6 [PMLGroup1_Z_1, oriented by FaceCS6] = sweep_along_normal(RadiatingSurface.face(+x), length=96.513855mm)
  PML_RadiatingSurface_7 [PMLGroup1_XZ_1, oriented by FaceCS1] = sweep_along_normal(PML_RadiatingSurface_1.face(at (0, -76, 198.257)), length=96.513855mm)
  PML_RadiatingSurface_8 [PMLGroup1_YZ_1, oriented by FaceCS4] = sweep_along_normal(PML_RadiatingSurface_1.face(at (-76, 0, 198.257)), length=96.513855mm)
  PML_RadiatingSurface_9 [PMLGroup1_YZ_1, oriented by FaceCS5] = sweep_along_normal(PML_RadiatingSurface_1.face(at (0, 76, 198.257)), length=96.513855mm)
  PML_RadiatingSurface_10 [PMLGroup1_YZ_1, oriented by FaceCS1] = sweep_along_normal(PML_RadiatingSurface_1.face(at (76, 0, 198.257)), length=96.513855mm)
  PML_RadiatingSurface_11 [PMLGroup1_YZ_1, oriented by FaceCS2] = sweep_along_normal(PML_RadiatingSurface_2.face(at (0, -76, -198.257)), length=96.513855mm)
  coordinate_system FaceCS7 = face of RadiatingSurface: Origin=(-76, -76, -150) FaceID=RadiatingSurface.face(-z) AxisPosn=(-76, 76, -150) WhichAxis=X ZRotationAngle=0deg XOffset=0mm YOffset=0mm FaceNormal(0, 0, -1)
  PML_RadiatingSurface_12 [PMLGroup1_YZ_1, oriented by FaceCS7] = sweep_along_normal(PML_RadiatingSurface_2.face(at (-76, 0, -198.257)), length=96.513855mm)
  coordinate_system FaceCS8 = face of RadiatingSurface: Origin=(-76, 76, -150) FaceID=RadiatingSurface.face(-z) AxisPosn=(76, 76, -150) WhichAxis=X ZRotationAngle=0deg XOffset=0mm YOffset=0mm FaceNormal(0, 0, -1)
  PML_RadiatingSurface_13 [PMLGroup1_YZ_1, oriented by FaceCS8] = sweep_along_normal(PML_RadiatingSurface_2.face(at (0, 76, -198.257)), length=96.513855mm)
  PML_RadiatingSurface_14 [PMLGroup1_XZ_1, oriented by FaceCS2] = sweep_along_normal(PML_RadiatingSurface_2.face(at (76, 0, -198.257)), length=96.513855mm)
  PML_RadiatingSurface_15 [PMLGroup1_XZ_1, oriented by FaceCS4] = sweep_along_normal(PML_RadiatingSurface_3.face(at (-76, -124.257, 0)), length=96.513855mm)
  PML_RadiatingSurface_16 [PMLGroup1_XZ_1, oriented by FaceCS3] = sweep_along_normal(PML_RadiatingSurface_3.face(at (76, -124.257, 0)), length=96.513855mm)
  PML_RadiatingSurface_17 [PMLGroup1_XZ_1, oriented by FaceCS5] = sweep_along_normal(PML_RadiatingSurface_4.face(at (-124.257, 76, 0)), length=96.513855mm)
  PML_RadiatingSurface_18 [PMLGroup1_YZ_1, oriented by FaceCS6] = sweep_along_normal(PML_RadiatingSurface_5.face(at (76, 124.257, 0)), length=96.513855mm)
  PML_RadiatingSurface_19 [PMLGroup1_XYZ_1, oriented by FaceCS4] = sweep_along_normal(PML_RadiatingSurface_7.face(at (-76, -124.257, 198.257)), length=96.513855mm)
  PML_RadiatingSurface_20 [PMLGroup1_XYZ_1, oriented by FaceCS1] = sweep_along_normal(PML_RadiatingSurface_7.face(at (76, -124.257, 198.257)), length=96.513855mm)
  PML_RadiatingSurface_21 [PMLGroup1_XYZ_1, oriented by FaceCS5] = sweep_along_normal(PML_RadiatingSurface_8.face(at (-124.257, 76, 198.257)), length=96.513855mm)
  coordinate_system FaceCS9 = face of RadiatingSurface: Origin=(76, 76, 150) FaceID=RadiatingSurface.face(+z) AxisPosn=(-76, 76, 150) WhichAxis=X ZRotationAngle=0deg XOffset=0mm YOffset=0mm FaceNormal(0, 0, 1)
  PML_RadiatingSurface_22 [PMLGroup1_XYZ_1, oriented by FaceCS9] = sweep_along_normal(PML_RadiatingSurface_9.face(at (76, 124.257, 198.257)), length=96.513855mm)
  PML_RadiatingSurface_23 [PMLGroup1_XYZ_1, oriented by FaceCS7] = sweep_along_normal(PML_RadiatingSurface_11.face(at (-76, -124.257, -198.257)), length=96.513855mm)
  PML_RadiatingSurface_24 [PMLGroup1_XYZ_1, oriented by FaceCS2] = sweep_along_normal(PML_RadiatingSurface_11.face(at (76, -124.257, -198.257)), length=96.513855mm)
  PML_RadiatingSurface_25 [PMLGroup1_XYZ_1, oriented by FaceCS8] = sweep_along_normal(PML_RadiatingSurface_12.face(at (-124.257, 76, -198.257)), length=96.513855mm)
  PML_RadiatingSurface_26 [PMLGroup1_XYZ_1, oriented by FaceCS6] = sweep_along_normal(PML_RadiatingSurface_13.face(at (76, 124.257, -198.257)), length=96.513855mm)
  group PMLGroup1 = PML_RadiatingSurface_1..PML_RadiatingSurface_26
boundaries and excitations:
  PML_radiation1: Radiation Faces=RadiatingSurface.face(+z) IsForPML
  PML_radiation2: Radiation Faces=RadiatingSurface.face(-z) IsForPML
  PML_radiation3: Radiation Faces=RadiatingSurface.face(-y) IsForPML
  PML_radiation4: Radiation Faces=RadiatingSurface.face(-x) IsForPML
  PML_radiation5: Radiation Faces=RadiatingSurface.face(+y) IsForPML
  PML_radiation6: Radiation Faces=RadiatingSurface.face(+x) IsForPML
  1: Lumped Port Objects=P1 LumpedPortType=Modal Modes{Mode1{IntLine{(0, 0, -0.5) -> (0, 0, 0.5)} CharImp=Zpi RenormImp=50ohm}} Impedance=50ohm
setups:
  1GHz: HfssDriven Frequency=1GHz MaxDeltaS=0.02 MaximumPasses=99 MinimumPasses=1 MinimumConvergedPasses=1 PercentRefinement=30 BasisOrder=1 PortAccuracy=2 DrivenSolverType="Direct Solver"
    sweep 800MHz_1200MHz: 800MHz to 1200MHz step 1MHz; Type=Interpolating InterpTolerance=0.5 InterpMaxSolns=250 InterpUsePortImped=false PassivityErrorTolerance=0.0001
source amplitudes:
  1:1: 1V 0deg
radiation setups:
  3D: Infinite Sphere Theta=0deg..180deg step 2deg Phi=-180deg..180deg step 2deg
  Elevation: Infinite Sphere Theta=-180deg..180deg step 1deg Phi=0deg..90deg step 90deg
  Azimuth: Infinite Sphere Theta=90deg..90deg step 0deg Phi=-180deg..180deg step 1deg
reports:
  Terminal S Parameter Plot 1: dB(St(1,1)) vs Freq on 1GHz : 800MHz_1200MHz
  S Parameter Plot 1: dB(S(1,1)) vs Freq on 1GHz : 800MHz_1200MHz
  S Parameter Plot 2: dB(S(1,1)) vs Freq on 1GHz : 800MHz_1200MHz
  S Parameter Plot 3: dB(S(1,1)) vs Freq on 1GHz : 800MHz_1200MHz
  Gain Plot 1: GainTotal vs Phi, Theta on 1GHz : LastAdaptive, 3D [Freq=1GHz]
