# Ansys Electronics Desktop project, version 2023.2
materials:
  vacuum: permittivity=1
  pec: conductivity=1e+30

design HFSSDesign1 (HFSS, HFSS Terminal Network, model units mm)
variables:
  dL = 0
  dR = 1mm
  dH = 20.8
  gH = 1mm
  gR = 10mm
  nH = 10mm
geometry:
  dip1 [pec] = cylinder(axis=Z, base_centre=(0mm, 0mm, -dH/2), radius=gR, height=dH)
  gap [vacuum] = cylinder(axis=Z, base_centre=(0, 0, 0), radius=gR, height=nH)
