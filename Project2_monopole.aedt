# Ansys Electronics Desktop project, version 2023.2
materials:
  vacuum: permittivity=1
  pec: conductivity=1e+30
  PMLGroup1_Z_1: permittivity{anisotropic component1=1.7689241 component2=1.7689241 component3=0.2826577} permeability{anisotropic component1=1.7689241 component2=1.7689241 component3=0.2826577} dielectric_loss_tangent{anisotropic component1=1 component2=1 component3=-1} magnetic_loss_tangent{anisotropic component1=1 component2=1 component3=-1}
  PMLGroup1_XZ_1: permittivity{anisotropic component1=1 component2=0.01 component3=1} permeability{anisotropic component1=1 component2=0.01 component3=1} dielectric_loss_tangent{anisotropic component1=0 component2=625.81846 component3=0} magnetic_loss_tangent{anisotropic component1=0 component2=625.81846 component3=0}
  PMLGroup1_YZ_1: permittivity{anisotropic component1=0.01 component2=1 component3=1} permeability{anisotropic component1=0.01 component2=1 component3=1} dielectric_loss_tangent{anisotropic component1=625.81846 component2=0 component3=0} magnetic_loss_tangent{anisotropic component1=625.81846 component2=0 component3=0}
  PMLGroup1_XYZ_1: permittivity{anisotropic component1=1.7689241 component2=1.7689241 component3=1.7689241} permeability{anisotropic component1=1.7689241 component2=1.7689241 component3=1.7689241} dielectric_loss_tangent{anisotropic component1=1 component2=1 component3=1} magnetic_loss_tangent{anisotropic component1=1 component2=1 component3=1}
  PMLGroup2_Z_1: permittivity{anisotropic component1=1.1740014 component2=1.1740014 component3=0.42589389} permeability{anisotropic component1=1.1740014 component2=1.1740014 component3=0.42589389} dielectric_loss_tangent{anisotropic component1=1 component2=1 component3=-1} magnetic_loss_tangent{anisotropic component1=1 component2=1 component3=-1}
  PMLGroup2_XZ_1: permittivity{anisotropic component1=1 component2=0.01 component3=1} permeability{anisotropic component1=1 component2=0.01 component3=1} dielectric_loss_tangent{anisotropic component1=0 component2=275.65584 component3=0} magnetic_loss_tangent{anisotropic component1=0 component2=275.65584 component3=0}
  PMLGroup2_YZ_1: permittivity{anisotropic component1=0.01 component2=1 component3=1} permeability{anisotropic component1=0.01 component2=1 component3=1} dielectric_loss_tangent{anisotropic component1=275.65584 component2=0 component3=0} magnetic_loss_tangent{anisotropic component1=275.65584 component2=0 component3=0}
  PMLGroup2_XYZ_1: permittivity{anisotropic component1=1.1740014 component2=1.1740014 component3=1.1740014} permeability{anisotropic component1=1.1740014 component2=1.1740014 component3=1.1740014} dielectric_loss_tangent{anisotropic component1=1 component2=1 component3=1} magnetic_loss_tangent{anisotropic component1=1 component2=1 component3=1}

design HFSSDesign1 (HFSS, HFSS Modal Network, model units mm)
variables:
  dl = 150mm
  dr = 1mm
  gl = 1
geometry:
  gap [vacuum] = cylinder(axis=Z, base_centre=(0mm, 0mm, -0.5mm), radius=1mm, height=1mm)
  P1 = gap.section(plane=YZ)
  Dipole [pec] = cylinder(axis=Z, base_centre=(0mm, 0mm, -46.5mm), radius=1mm, height=93mm)
  RadiatingSurface [vacuum] = region(absolute_offset=23.4375mm on all sides)
  coordinate_system FaceCS1 = face of RadiatingSurface: Origin=(24.4375, -24.4375, 69.9375) FaceID=RadiatingSurface.face(+z) AxisPosn=(24.4375, 24.4375, 69.9375) WhichAxis=X ZRotationAngle=0deg XOffset=0mm YOffset=0mm FaceNormal(0, 0, 1)
  PML_RadiatingSurface_1 [PMLGroup2_Z_1, oriented by FaceCS1] = sweep_along_normal(RadiatingSurface.face(+z), length=35.706656mm)
  coordinate_system FaceCS2 = face of RadiatingSurface: Origin=(24.4375, -24.4375, -69.9375) FaceID=RadiatingSurface.face(-z) AxisPosn=(-24.4375, -24.4375, -69.9375) WhichAxis=X ZRotationAngle=0deg XOffset=0mm YOffset=0mm FaceNormal(0, 0, -1)
  PML_RadiatingSurface_2 [PMLGroup2_Z_1, oriented by FaceCS2] = sweep_along_normal(RadiatingSurface.face(-z), length=35.706656mm)
  coordinate_system FaceCS3 = face of RadiatingSurface: Origin=(24.4375, -24.4375, 69.9375) FaceID=RadiatingSurface.face(-y) AxisPosn=(-24.4375, -24.4375, 69.9375) WhichAxis=X ZRotationAngle=0deg XOffset=0mm YOffset=0mm FaceNormal(0, -1, 0)
  PML_RadiatingSurface_3 [PMLGroup2_Z_1, oriented by FaceCS3] = sweep_along_normal(RadiatingSurface.face(-y), length=35.706656mm)
  coordinate_system FaceCS4 = face of RadiatingSurface: Origin=(-24.4375, -24.4375, 69.9375) FaceID=RadiatingSurface.face(-x) AxisPosn=(-24.4375, 24.4375, 69.9375) WhichAxis=X ZRotationAngle=0deg XOffset=0mm YOffset=0mm FaceNormal(-1, 0, 0)
  PML_RadiatingSurface_4 [PMLGroup2_Z_1, oriented by FaceCS4] = sweep_along_normal(RadiatingSurface.face(-x), length=35.706656mm)
  coordinate_system FaceCS5 = face of RadiatingSurface: Origin=(-24.4375, 24.4375, 69.9375) FaceID=RadiatingSurface.face(+y) AxisPosn=(24.4375, 24.4375, 69.9375) WhichAxis=X ZRotationAngle=0deg XOffset=0mm YOffset=0mm FaceNormal(0, 1, 0)
  PML_RadiatingSurface_5 [PMLGroup2_Z_1, oriented by FaceCS5] = sweep_along_normal(RadiatingSurface.face(+y), length=35.706656mm)
  coordinate_system FaceCS6 = face of RadiatingSurface: Origin=(24.4375, 24.4375, -69.9375) FaceID=RadiatingSurface.face(+x) AxisPosn=(24.4375, 24.4375, 69.9375) WhichAxis=X ZRotationAngle=0deg XOffset=0mm YOffset=0mm FaceNormal(1, 0, 0)
  PML_RadiatingSurface_6 [PMLGroup2_Z_1, oriented by FaceCS6] = sweep_along_normal(RadiatingSurface.face(+x), length=35.706656mm)
  PML_RadiatingSurface_7 [PMLGroup2_XZ_1, oriented by FaceCS1] = sweep_along_normal(PML_RadiatingSurface_1.face(at (0, -24.4375, 87.7908)), length=35.706656mm)
  PML_RadiatingSurface_8 [PMLGroup2_YZ_1, oriented by FaceCS4] = sweep_along_normal(PML_RadiatingSurface_1.face(at (-24.4375, 0, 87.7908)), length=35.706656mm)
  PML_RadiatingSurface_9 [PMLGroup2_YZ_1, oriented by FaceCS5] = sweep_along_normal(PML_RadiatingSurface_1.face(at (0, 24.4375, 87.7908)), length=35.706656mm)
  PML_RadiatingSurface_10 [PMLGroup2_YZ_1, oriented by FaceCS1] = sweep_along_normal(PML_RadiatingSurface_1.face(at (24.4375, 0, 87.7908)), length=35.706656mm)
  PML_RadiatingSurface_11 [PMLGroup2_YZ_1, oriented by FaceCS2] = sweep_along_normal(PML_RadiatingSurface_2.face(at (0, -24.4375, -87.7908)), length=35.706656mm)
  coordinate_system FaceCS7 = face of RadiatingSurface: Origin=(-24.4375, -24.4375, -69.9375) FaceID=RadiatingSurface.face(-z) AxisPosn=(-24.4375, 24.4375, -69.9375) WhichAxis=X ZRotationAngle=0deg XOffset=0mm YOffset=0mm FaceNormal(0, 0, -1)
  PML_RadiatingSurface_12 [PMLGroup2_YZ_1, oriented by FaceCS7] = sweep_along_normal(PML_RadiatingSurface_2.face(at (-24.4375, 0, -87.7908)), length=35.706656mm)
  coordinate_system FaceCS8 = face of RadiatingSurface: Origin=(-24.4375, 24.4375, -69.9375) FaceID=RadiatingSurface.face(-z) AxisPosn=(24.4375, 24.4375, -69.9375) WhichAxis=X ZRotationAngle=0deg XOffset=0mm YOffset=0mm FaceNormal(0, 0, -1)
  PML_RadiatingSurface_13 [PMLGroup2_YZ_1, oriented by FaceCS8] = sweep_along_normal(PML_RadiatingSurface_2.face(at (0, 24.4375, -87.7908)), length=35.706656mm)
  PML_RadiatingSurface_14 [PMLGroup2_XZ_1, oriented by FaceCS2] = sweep_along_normal(PML_RadiatingSurface_2.face(at (24.4375, 0, -87.7908)), length=35.706656mm)
  PML_RadiatingSurface_15 [PMLGroup2_XZ_1, oriented by FaceCS4] = sweep_along_normal(PML_RadiatingSurface_3.face(at (-24.4375, -42.2908, 0)), length=35.706656mm)
  PML_RadiatingSurface_16 [PMLGroup2_XZ_1, oriented by FaceCS3] = sweep_along_normal(PML_RadiatingSurface_3.face(at (24.4375, -42.2908, 0)), length=35.706656mm)
  PML_RadiatingSurface_17 [PMLGroup2_XZ_1, oriented by FaceCS5] = sweep_along_normal(PML_RadiatingSurface_4.face(at (-42.2908, 24.4375, 0)), length=35.706656mm)
  PML_RadiatingSurface_18 [PMLGroup2_YZ_1, oriented by FaceCS6] = sweep_along_normal(PML_RadiatingSurface_5.face(at (24.4375, 42.2908, 0)), length=35.706656mm)
  PML_RadiatingSurface_19 [PMLGroup2_XYZ_1, oriented by FaceCS4] = sweep_along_normal(PML_RadiatingSurface_7.face(at (-24.4375, -42.2908, 87.7908)), length=35.706656mm)
  PML_RadiatingSurface_20 [PMLGroup2_XYZ_1, oriented by FaceCS1] = sweep_along_normal(PML_RadiatingSurface_7.face(at (24.4375, -42.2908, 87.7908)), length=35.706656mm)
  PML_RadiatingSurface_21 [PMLGroup2_XYZ_1, oriented by FaceCS5] = sweep_along_normal(PML_RadiatingSurface_8.face(at (-42.2908, 24.4375, 87.7908)), length=35.706656mm)
  coordinate_system FaceCS9 = face of RadiatingSurface: Origin=(24.4375, 24.4375, 69.9375) FaceID=RadiatingSurface.face(+z) AxisPosn=(-24.4375, 24.4375, 69.9375) WhichAxis=X ZRotationAngle=0deg XOffset=0mm YOffset=0mm FaceNormal(0, 0, 1)
  PML_RadiatingSurface_22 [PMLGroup2_XYZ_1, oriented by FaceCS9] = sweep_along_normal(PML_RadiatingSurface_9.face(at (24.4375, 42.2908, 87.7908)), length=35.706656mm)
  PML_RadiatingSurface_23 [PMLGroup2_XYZ_1, oriented by FaceCS7] = sweep_along_normal(PML_RadiatingSurface_11.face(at (-24.4375, -42.2908, -87.7908)), length=35.706656mm)
  PML_RadiatingSurface_24 [PMLGroup2_XYZ_1, oriented by FaceCS2] = sweep_along_normal(PML_RadiatingSurface_11.face(at (24.4375, -42.2908, -87.7908)), length=35.706656mm)
  PML_RadiatingSurface_25 [PMLGroup2_XYZ_1, oriented by FaceCS8] = sweep_along_normal(PML_RadiatingSurface_12.face(at (-42.2908, 24.4375, -87.7908)), length=35.706656mm)
  PML_RadiatingSurface_26 [PMLGroup2_XYZ_1, oriented by FaceCS6] = sweep_along_normal(PML_RadiatingSurface_13.face(at (24.4375, 42.2908, -87.7908)), length=35.706656mm)
  group PMLGroup2 = PML_RadiatingSurface_1..PML_RadiatingSurface_26
boundaries and excitations:
  PML_radiation1: Radiation Faces=RadiatingSurface.face(+z) IsForPML
  PML_radiation2: Radiation Faces=RadiatingSurface.face(-z) IsForPML
  PML_radiation3: Radiation Faces=RadiatingSurface.face(-y) IsForPML
  PML_radiation4: Radiation Faces=RadiatingSurface.face(-x) IsForPML
  PML_radiation5: Radiation Faces=RadiatingSurface.face(+y) IsForPML
  PML_radiation6: Radiation Faces=RadiatingSurface.face(+x) IsForPML
  1: Lumped Port Objects=P1 LumpedPortType=Modal Modes{Mode1{IntLine{(0, 0, -0.5) -> (0, 0, 0.5)} CharImp=Zpi RenormImp=50ohm}} Impedance=50ohm
setups:
  Setup1: HfssDriven Frequency=1GHz Matrix_Convergence{AllDiagEntries DiagonalMag=0.02 DiagonalPhase=5deg MagMinThreshold=0.01} MaximumPasses=18 MinimumPasses=1 MinimumConvergedPasses=1 PercentRefinement=30 BasisOrder=1 PortAccuracy=2 DrivenSolverType="Direct Solver"
    sweep Sweep: 0.5GHz to 1.5GHz, 101 points; Type=Interpolating SaveFields InterpTolerance=0.5 InterpMaxSolns=250 InterpUsePortImped=false PassivityErrorTolerance=0.0001
source amplitudes:
  1:1: 1W 0deg
radiation setups:
  3D: Infinite Sphere Theta=0deg..180deg step 2deg Phi=-180deg..180deg step 2deg
  Elevation: Infinite Sphere Theta=-180deg..180deg step 1deg Phi=0deg..90deg step 90deg
  Azimuth: Infinite Sphere Theta=90deg..90deg step 0deg Phi=-180deg..180deg step 1deg
reports:
  S Parameter Plot 1: dB(S(1,1)) vs Freq on Setup1 : Sweep; markers m1 at 1.42GHz
